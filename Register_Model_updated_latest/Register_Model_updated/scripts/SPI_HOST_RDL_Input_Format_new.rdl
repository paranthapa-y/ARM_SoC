// Auto-generated by excel_to_rdl.py -- DO NOT EDIT BY HAND
// Source: SPI_HOST_RDL_Input_Format_new.xlsx
// Target: ARM CMSDK AHB lite  SPI_HOST_RDL_Input_Format_new Programmer's Model

addrmap SPI_HOST_RDL_Input_Format_new {
    name = "ARM CMSDK AHB lite SPI_HOST_RDL_Input_Format_new";
    desc = "Register map for the ARM CMSDK AHB lite SPI_HOST_RDL_Input_Format_new peripheral.";

    reg {
        name = "INTERRUPT_STATE";
        desc = "Interrupt State Register. Bit set by hardware when the event occurs; software writes 1 to clear.";
        regwidth = 32;

        field {
            sw = r;
            hw = na;
            reset = 0;
        } RESERVED_31_2[31:2];
        field {
            desc = "Set by hardware when an enabled SPI operational event occurs (see EVENT_ENABLE/STATUS). Drives the spi_event interrupt line to the core. Software clears by writing 1.";
            sw = rw;
            hw = w;
            onwrite = woclr;
            reset = 0;
        } SPI_EVENT[1:1];
        field {
            desc = "Set by hardware when an ERROR-class event occurs (see ERROR_ENABLE/ERROR_STATUS). Drives the error interrupt line to the core. Software clears by writing 1.";
            sw = rw;
            hw = w;
            onwrite = woclr;
            reset = 0;
        } ERROR[0:0];
    } INTERRUPT_STATE @ 0x000;

    reg {
        name = "INTERRUPT_ENABLE";
        desc = "Interrupt Enable Register.";
        regwidth = 32;

        field {
            sw = r;
            hw = na;
            reset = 0;
        } RESERVED_31_2[31:2];
        field {
            desc = "Enables the spi_event interrupt: when set, a set INTERRUPT_STATE.SPI_EVENT bit is forwarded as an interrupt to the core.";
            sw = rw;
            hw = r;
            reset = 0;
        } SPI_EVENT[1:1];
        field {
            desc = "Enables the error interrupt: when set, a set INTERRUPT_STATE.ERROR bit is forwarded as an interrupt to the core.";
            sw = rw;
            hw = r;
            reset = 0;
        } ERROR[0:0];
    } INTERRUPT_ENABLE @ 0x004;

    reg {
        name = "INTERRUPT_TEST";
        desc = "Interrupt Test Register. Write 1 to force the corresponding interrupt for verification.";
        regwidth = 32;

        field {
            sw = r;
            hw = na;
            reset = 0;
        } RESERVED_31_2[31:2];
        field {
            desc = "Software write of 1 forces INTERRUPT_STATE.SPI_EVENT to assert, for verifying the spi_event interrupt path without a real event condition.";
            sw = w;
            hw = r;
            reset = 0;
        } SPI_EVENT[1:1];
        field {
            desc = "Software write of 1 forces INTERRUPT_STATE.ERROR to assert, for verifying the error interrupt path without a real error condition.";
            sw = w;
            hw = r;
            reset = 0;
        } ERROR[0:0];
    } INTERRUPT_TEST @ 0x008;

    reg {
        name = "ALERT_TEST";
        desc = "Alert Test Register. Write 1 to trigger one alert event of the fatal_fault kind.";
        regwidth = 32;

        field {
            sw = r;
            hw = na;
            reset = 0;
        } RESERVED_31_1[31:1];
        field {
            desc = "Software write of 1 forces one instance of the fatal_fault alert, for verifying the alert path end-to-end. fatal_fault is triggered for real when a fatal TL-UL bus integrity fault is detected.";
            sw = w;
            hw = r;
            reset = 0;
        } FATAL_FAULT[0:0];
    } ALERT_TEST @ 0x00C;

    reg {
        name = "CONTROL";
        desc = "Control register. Top-level enable, reset, output-buffer control, and TX/RX FIFO watermark levels for the SPI host core.";
        regwidth = 32;

        field {
            desc = "Top-level enable for the SPI host core. When 0 (reset default), no SPI transactions can proceed. Clearing it while a transaction is active stops SCK toggling and stops cs_n from asserting for any new transfer.";
            sw = rw;
            hw = r;
            reset = 0;
        } SPIEN[31:31];
        field {
            desc = "Software reset. When set to 1, resets the entire IP core: FIFOs, CDC logic, the core FSM, and the shift register. CDC FIFOs are drained rather than hard-cleared, so software must confirm both FIFOs are empty before releasing SW_RST.";
            sw = rw;
            hw = r;
            reset = 0;
        } SW_RST[30:30];
        field {
            desc = "Enables the SPI host's output buffers for sck, csb, and sd. Lets the IP share a bus with other SPI controllers without driving it while disabled.";
            sw = rw;
            hw = r;
            reset = 0;
        } OUTPUT_EN[29:29];
        field {
            sw = r;
            hw = na;
            reset = 0;
        } RESERVED_28_16[28:16];
        field {
            desc = "TX FIFO watermark level (32-bit words). If EVENT_ENABLE.TXWM is set, hardware sends a spi_event interrupt once the TX FIFO depth drops below this many words.";
            sw = rw;
            hw = r;
            reset = 0;
        } TX_WATERMARK[15:8];
        field {
            desc = "RX FIFO watermark level (32-bit words). If EVENT_ENABLE.RXWM is set, hardware sends a spi_event interrupt once the RX FIFO depth reaches this many words.";
            sw = rw;
            hw = r;
            reset = 127;
        } RX_WATERMARK[7:0];
    } CONTROL @ 0x010;

    reg {
        name = "STATUS";
        desc = "Status register. Read-only snapshot of FIFO occupancy/flags and core FSM state (ready/active).";
        regwidth = 32;

        field {
            desc = "High when the SPI host command queue can accept a new command. Writing COMMAND while this is low is an error and triggers a CMDBUSY interrupt.";
            sw = r;
            hw = w;
            reset = 0;
        } READY[31:31];
        field {
            desc = "High while the SPI host FSM is currently processing an issued command (mid-transaction on the SPI bus). EVENT_ENABLE.IDLE fires a spi_event interrupt when this bit falls to 0.";
            sw = r;
            hw = w;
            reset = 0;
        } ACTIVE[30:30];
        field {
            desc = "High when the TX FIFO is full. Further writes to TXDATA while set are an error and cause an OVERFLOW interrupt.";
            sw = r;
            hw = w;
            reset = 0;
        } TXFULL[29:29];
        field {
            desc = "High when the TX FIFO is empty.";
            sw = r;
            hw = w;
            reset = 0;
        } TXEMPTY[28:28];
        field {
            desc = "High when an ongoing SPI transaction has stalled because the TX FIFO has no data ready to send.";
            sw = r;
            hw = w;
            reset = 0;
        } TXSTALL[27:27];
        field {
            desc = "High when the TX FIFO word count has fallen below the CONTROL.TX_WATERMARK level; contributes to the spi_event interrupt if EVENT_ENABLE.TXWM is set.";
            sw = r;
            hw = w;
            reset = 0;
        } TXWM[26:26];
        field {
            desc = "High when the RX FIFO is full. Ongoing transactions stall until firmware reads data out via RXDATA.";
            sw = r;
            hw = w;
            reset = 0;
        } RXFULL[25:25];
        field {
            desc = "High when the RX FIFO is empty. Reading RXDATA while this is set is an error and causes an UNDERFLOW interrupt.";
            sw = r;
            hw = w;
            reset = 0;
        } RXEMPTY[24:24];
        field {
            desc = "High when an ongoing SPI transaction has stalled because the RX FIFO has no space to accept incoming data.";
            sw = r;
            hw = w;
            reset = 0;
        } RXSTALL[23:23];
        field {
            desc = "Read-only mirror of the ByteOrder RTL parameter (fixed at synthesis), so firmware can confirm the IP was built with the expected byte ordering. No resval is given for this field in the source hjson (unlike every other STATUS bit) -- reset value is left undefined here rather than assumed; in practice it reflects the ByteOrder parameter default of 1, but this should be confirmed against the actual synthesized netlist/parameter binding before relying on it.";
            sw = r;
            hw = w;
        } BYTEORDER[22:22];
        field {
            sw = r;
            hw = na;
            reset = 0;
        } RESERVED_21[21:21];
        field {
            desc = "High when the RX FIFO word count has exceeded the CONTROL.RX_WATERMARK level; contributes to the spi_event interrupt if EVENT_ENABLE.RXWM is set.";
            sw = r;
            hw = w;
            reset = 0;
        } RXWM[20:20];
        field {
            desc = "Command queue depth: number of unread 32-bit command-segment words currently queued in the command FIFO.";
            sw = r;
            hw = w;
            reset = 0;
        } CMDQD[19:16];
        field {
            desc = "Receive queue depth: number of unread 32-bit words currently held in the RX FIFO. May read as an underestimate while active, due to CDC synchronization delay.";
            sw = r;
            hw = w;
            reset = 0;
        } RXQD[15:8];
        field {
            desc = "Transmit queue depth: number of unsent 32-bit words currently held in the TX FIFO. May read as an overestimate while active, due to CDC synchronization delay.";
            sw = r;
            hw = w;
            reset = 0;
        } TXQD[7:0];
    } STATUS @ 0x014;

    reg {
        name = "CONFIGOPTS0";
        desc = "Configuration options register for cs_n line 0 (CONFIGOPTS multireg, index 0 of NumCS=2). Per-device clock, timing, and SPI mode settings.";
        regwidth = 32;

        field {
            desc = "Clock polarity for cs_n line 0. CPOL=0: SCK idles low and pulses high. CPOL=1: SCK idles high and pulses low.";
            sw = rw;
            hw = r;
            reset = 0;
        } CPOL[31:31];
        field {
            desc = "Clock phase for cs_n line 0. CPHA=0: data changes on the trailing SCK edge and is sampled on the leading edge. CPHA=1: data changes on the leading edge and is sampled on the trailing edge. Must match the target device; sampling is further modified by FULLCYC.";
            sw = rw;
            hw = r;
            reset = 0;
        } CPHA[30:30];
        field {
            desc = "Full-cycle sampling mode for cs_n line 0. When set, delays the RX sample point by a full SCK cycle after the data-shift edge (instead of the default half cycle), giving the device more setup time; interacts with CPHA.";
            sw = rw;
            hw = r;
            reset = 0;
        } FULLCYC[29:29];
        field {
            sw = r;
            hw = na;
            reset = 0;
        } RESERVED_28[28:28];
        field {
            desc = "CS_N leading time for cs_n line 0: number of SCK half-cycles, CSNLEAD+1, held between the falling edge of cs_n and the first SCK edge; 0 gives the minimum one-half-cycle delay.";
            sw = rw;
            hw = r;
            reset = 0;
        } CSNLEAD[27:24];
        field {
            desc = "CS_N trailing time for cs_n line 0: number of SCK half-cycles, CSNTRAIL+1, held between the last SCK edge and the rising edge of cs_n; 0 gives the minimum one-half-cycle delay.";
            sw = rw;
            hw = r;
            reset = 0;
        } CSNTRAIL[23:20];
        field {
            desc = "Minimum idle time for cs_n line 0: number of SCK half-cycles cs_n is held high between back-to-back commands (actual idle = CSNIDLE+1 half-cycles; 0 gives the minimum one-half-cycle pulse).";
            sw = rw;
            hw = r;
            reset = 0;
        } CSNIDLE[19:16];
        field {
            desc = "Core clock divider for cs_n line 0. SCK period becomes 2*(CLKDIV+1)*T(core), slowing SCK relative to the core clock by a factor of (CLKDIV+1).";
            sw = rw;
            hw = r;
            reset = 0;
        } CLKDIV[15:0];
    } CONFIGOPTS0 @ 0x018;

    reg {
        name = "CONFIGOPTS1";
        desc = "Configuration options register for cs_n line 1 (CONFIGOPTS multireg, index 1 of NumCS=2). Per-device clock, timing, and SPI mode settings.";
        regwidth = 32;

        field {
            desc = "Clock polarity for cs_n line 1. CPOL=0: SCK idles low and pulses high. CPOL=1: SCK idles high and pulses low.";
            sw = rw;
            hw = r;
            reset = 0;
        } CPOL[31:31];
        field {
            desc = "Clock phase for cs_n line 1. CPHA=0: data changes on the trailing SCK edge and is sampled on the leading edge. CPHA=1: data changes on the leading edge and is sampled on the trailing edge. Must match the target device; sampling is further modified by FULLCYC.";
            sw = rw;
            hw = r;
            reset = 0;
        } CPHA[30:30];
        field {
            desc = "Full-cycle sampling mode for cs_n line 1. When set, delays the RX sample point by a full SCK cycle after the data-shift edge (instead of the default half cycle), giving the device more setup time; interacts with CPHA.";
            sw = rw;
            hw = r;
            reset = 0;
        } FULLCYC[29:29];
        field {
            sw = r;
            hw = na;
            reset = 0;
        } RESERVED_28[28:28];
        field {
            desc = "CS_N leading time for cs_n line 1: number of SCK half-cycles, CSNLEAD+1, held between the falling edge of cs_n and the first SCK edge; 0 gives the minimum one-half-cycle delay.";
            sw = rw;
            hw = r;
            reset = 0;
        } CSNLEAD[27:24];
        field {
            desc = "CS_N trailing time for cs_n line 1: number of SCK half-cycles, CSNTRAIL+1, held between the last SCK edge and the rising edge of cs_n; 0 gives the minimum one-half-cycle delay.";
            sw = rw;
            hw = r;
            reset = 0;
        } CSNTRAIL[23:20];
        field {
            desc = "Minimum idle time for cs_n line 1: number of SCK half-cycles cs_n is held high between back-to-back commands (actual idle = CSNIDLE+1 half-cycles; 0 gives the minimum one-half-cycle pulse).";
            sw = rw;
            hw = r;
            reset = 0;
        } CSNIDLE[19:16];
        field {
            desc = "Core clock divider for cs_n line 1. SCK period becomes 2*(CLKDIV+1)*T(core), slowing SCK relative to the core clock by a factor of (CLKDIV+1).";
            sw = rw;
            hw = r;
            reset = 0;
        } CLKDIV[15:0];
    } CONFIGOPTS1 @ 0x01C;

    reg {
        name = "CSID";
        desc = "Chip-Select ID. Controls which device to target with the next command.";
        regwidth = 32;

        field {
            desc = "Selects which cs_n line the next COMMAND targets. Latched into the core whenever COMMAND is written; the core then asserts cio_csb_o[CSID] for the duration of that command's execution.";
            sw = rw;
            hw = r;
            reset = 0;
        } CSID[31:0];
    } CSID @ 0x020;

    reg {
        name = "COMMAND";
        desc = "Command Register. Parameters specific to each command segment.";
        regwidth = 32;

        field {
            sw = r;
            hw = na;
            reset = 0;
        } RESERVED_31_14[31:14];
        field {
            desc = "Data direction for this segment: 0 = Dummy cycles (no TX/RX), 1 = RX only, 2 = TX only, 3 = Bidirectional TX/RX (Standard SPI speed only).";
            sw = w;
            hw = r;
            reset = 0;
        } DIRECTION[13:12];
        field {
            desc = "SPI speed mode for this segment: 0 = Standard (1-bit), 1 = Dual (2-bit), 2 = Quad (4-bit), 3 = Reserved.";
            sw = w;
            hw = r;
            reset = 0;
        } SPEED[11:10];
        field {
            desc = "Chip-select-active-after-transaction. 0: cs_n is raised immediately at the end of this segment. 1: cs_n is held low past the end of this segment, letting multiple segments (instruction, dummy cycles, data) be chained into one longer logical SPI transaction.";
            sw = w;
            hw = r;
            reset = 0;
        } CSAAT[9:9];
        field {
            desc = "Segment length. For read/write segments, the number of 1-byte bursts to transfer is LEN+1 (cycles per byte depend on SPEED). For dummy segments (DIRECTION=0), controls the number of dummy cycles issued (also LEN+1).";
            sw = w;
            hw = r;
            reset = 0;
        } LEN[8:0];
    } COMMAND @ 0x024;

    reg {
        name = "RXDATA";
        desc = "SPI Receive Data. Reads from this window pull data from the RX FIFO.";
        regwidth = 32;

        field {
            desc = "Each read pops one 32-bit word from the RX FIFO. Bytes are packed MSB-first per SPI convention, with the exact byte position controlled by the ByteOrder parameter. Reading while the RX FIFO is empty is an error (UNDERFLOW).";
            sw = r;
            hw = w;
            reset = 0;
        } RXDATA[31:0];
    } RXDATA @ 0x028;

    reg {
        name = "TXDATA";
        desc = "SPI Transmit Data. Data written to this window is placed into the TX FIFO.";
        regwidth = 32;

        field {
            desc = "Each write pushes one 32-bit word into the TX FIFO for serial transmission, most-significant-bit first per byte. Supports partial-word writes via TL-UL byte-enables (contiguous patterns only). Writing while the TX FIFO is full is an error (OVERFLOW); an illegal byte-enable pattern is an error (ACCESSINVAL) and is not accepted into the FIFO.";
            sw = w;
            hw = r;
            reset = 0;
        } TXDATA[31:0];
    } TXDATA @ 0x02C;

    reg {
        name = "ERROR_ENABLE";
        desc = "Controls which classes of errors raise an interrupt.";
        regwidth = 32;

        field {
            sw = r;
            hw = na;
            reset = 0;
        } RESERVED_31_5[31:5];
        field {
            desc = "When set, a command submitted with a CSID value that exceeds NumCS raises an error interrupt.";
            sw = rw;
            hw = r;
            reset = 1;
        } CSIDINVAL[4:4];
        field {
            desc = "When set, a command submitted with an invalid value for COMMAND.SPEED, or requesting bidirectional transfer at dual/quad speed, raises an error interrupt.";
            sw = rw;
            hw = r;
            reset = 1;
        } CMDINVAL[3:3];
        field {
            desc = "When set, a read from RXDATA while the RX FIFO is empty raises an error interrupt.";
            sw = rw;
            hw = r;
            reset = 1;
        } UNDERFLOW[2:2];
        field {
            desc = "When set, a TX FIFO overflow (write to TXDATA while full) raises an error interrupt.";
            sw = rw;
            hw = r;
            reset = 1;
        } OVERFLOW[1:1];
        field {
            desc = "When set, a command written to COMMAND while STATUS.READY is low raises an error interrupt (in addition to setting ERROR_STATUS.CMDBUSY, which happens regardless of this bit).";
            sw = rw;
            hw = r;
            reset = 1;
        } CMDBUSY[0:0];
    } ERROR_ENABLE @ 0x030;

    reg {
        name = "ERROR_STATUS";
        desc = "Indicates errors that have occurred. Software must clear (write 1) before issuing further commands.";
        regwidth = 32;

        field {
            sw = r;
            hw = na;
            reset = 0;
        } RESERVED_31_6[31:6];
        field {
            desc = "Set by hardware on a TXDATA bus write with an unsupported byte-enable pattern (all-zero, or non-contiguous byte lanes). Unlike the other ERROR_STATUS bits, this one is not maskable via ERROR_ENABLE and always contributes to the error interrupt. Clear by writing 1.";
            sw = rw;
            hw = rw;
            onwrite = woclr;
            reset = 0;
        } ACCESSINVAL[5:5];
        field {
            desc = "Set by hardware when a command is submitted with CSID exceeding NumCS. While any ERROR_STATUS bit is set, the SPI host FSM is stalled; clear by writing 1.";
            sw = rw;
            hw = rw;
            onwrite = woclr;
            reset = 0;
        } CSIDINVAL[4:4];
        field {
            desc = "Set by hardware on an invalid command segment: invalid COMMAND.SPEED, or a request for bidirectional transfer at dual/quad speed. While any ERROR_STATUS bit is set, the SPI host FSM is stalled; clear by writing 1.";
            sw = rw;
            hw = rw;
            onwrite = woclr;
            reset = 0;
        } CMDINVAL[3:3];
        field {
            desc = "Set by hardware when firmware reads RXDATA while the RX FIFO is empty. While any ERROR_STATUS bit is set, the SPI host FSM is stalled; clear by writing 1.";
            sw = rw;
            hw = rw;
            onwrite = woclr;
            reset = 0;
        } UNDERFLOW[2:2];
        field {
            desc = "Set by hardware when firmware overflows the TX FIFO (write to TXDATA while full). While any ERROR_STATUS bit is set, the SPI host FSM is stalled; clear by writing 1.";
            sw = rw;
            hw = rw;
            onwrite = woclr;
            reset = 0;
        } OVERFLOW[1:1];
        field {
            desc = "Set by hardware when software writes COMMAND while STATUS.READY = 0. While any ERROR_STATUS bit is set, the SPI host FSM is stalled; clear by writing 1.";
            sw = rw;
            hw = rw;
            onwrite = woclr;
            reset = 0;
        } CMDBUSY[0:0];
    } ERROR_STATUS @ 0x034;

    reg {
        name = "EVENT_ENABLE";
        desc = "Controls which classes of SPI events raise an interrupt.";
        regwidth = 32;

        field {
            sw = r;
            hw = na;
            reset = 0;
        } RESERVED_31_6[31:6];
        field {
            desc = "When set, a spi_event interrupt is sent whenever STATUS.ACTIVE transitions low (the SPI FSM has returned to idle; the whole segment sequence has drained onto the bus).";
            sw = rw;
            hw = r;
            reset = 0;
        } IDLE[5:5];
        field {
            desc = "When set, a spi_event interrupt is sent whenever STATUS.READY transitions high (command queue has room for a new COMMAND write).";
            sw = rw;
            hw = r;
            reset = 0;
        } READY[4:4];
        field {
            desc = "When set, a spi_event interrupt is sent whenever the TX FIFO word count drops below CONTROL.TX_WATERMARK. To stop re-firing, write more data to TXDATA or lower TX_WATERMARK.";
            sw = rw;
            hw = r;
            reset = 0;
        } TXWM[3:3];
        field {
            desc = "When set, a spi_event interrupt is sent whenever the RX FIFO word count exceeds CONTROL.RX_WATERMARK. To stop re-firing, read more data from RXDATA or raise RX_WATERMARK.";
            sw = rw;
            hw = r;
            reset = 0;
        } RXWM[2:2];
        field {
            desc = "When set, a spi_event interrupt is sent whenever STATUS.TXEMPTY asserts (TX FIFO empty).";
            sw = rw;
            hw = r;
            reset = 0;
        } TXEMPTY[1:1];
        field {
            desc = "When set, a spi_event interrupt is sent whenever STATUS.RXFULL asserts (RX FIFO full).";
            sw = rw;
            hw = r;
            reset = 0;
        } RXFULL[0:0];
    } EVENT_ENABLE @ 0x038;

};
